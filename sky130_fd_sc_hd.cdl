* Auto-generated from sky130_fd_sc_hd__tt_025C_1v80.lib by scripts/lib_to_cdl.py.
* Do not edit; regenerate by re-running the script.

.SUBCKT sky130_fd_sc_hd__a2111o_1 A1 A2 B1 C1 D1 X
*.PININFO A1:I A2:I B1:I C1:I D1:I X:O
.ENDS

.SUBCKT sky130_fd_sc_hd__a2111o_2 A1 A2 B1 C1 D1 X
*.PININFO A1:I A2:I B1:I C1:I D1:I X:O
.ENDS

.SUBCKT sky130_fd_sc_hd__a2111o_4 A1 A2 B1 C1 D1 X
*.PININFO A1:I A2:I B1:I C1:I D1:I X:O
.ENDS

.SUBCKT sky130_fd_sc_hd__a2111oi_0 A1 A2 B1 C1 D1 Y
*.PININFO A1:I A2:I B1:I C1:I D1:I Y:O
.ENDS

.SUBCKT sky130_fd_sc_hd__a2111oi_1 A1 A2 B1 C1 D1 Y
*.PININFO A1:I A2:I B1:I C1:I D1:I Y:O
.ENDS

.SUBCKT sky130_fd_sc_hd__a2111oi_2 A1 A2 B1 C1 D1 Y
*.PININFO A1:I A2:I B1:I C1:I D1:I Y:O
.ENDS

.SUBCKT sky130_fd_sc_hd__a2111oi_4 A1 A2 B1 C1 D1 Y
*.PININFO A1:I A2:I B1:I C1:I D1:I Y:O
.ENDS

.SUBCKT sky130_fd_sc_hd__a211o_1 A1 A2 B1 C1 X
*.PININFO A1:I A2:I B1:I C1:I X:O
.ENDS

.SUBCKT sky130_fd_sc_hd__a211o_2 A1 A2 B1 C1 X
*.PININFO A1:I A2:I B1:I C1:I X:O
.ENDS

.SUBCKT sky130_fd_sc_hd__a211o_4 A1 A2 B1 C1 X
*.PININFO A1:I A2:I B1:I C1:I X:O
.ENDS

.SUBCKT sky130_fd_sc_hd__a211oi_1 A1 A2 B1 C1 Y
*.PININFO A1:I A2:I B1:I C1:I Y:O
.ENDS

.SUBCKT sky130_fd_sc_hd__a211oi_2 A1 A2 B1 C1 Y
*.PININFO A1:I A2:I B1:I C1:I Y:O
.ENDS

.SUBCKT sky130_fd_sc_hd__a211oi_4 A1 A2 B1 C1 Y
*.PININFO A1:I A2:I B1:I C1:I Y:O
.ENDS

.SUBCKT sky130_fd_sc_hd__a21bo_1 A1 A2 B1_N X
*.PININFO A1:I A2:I B1_N:I X:O
.ENDS

.SUBCKT sky130_fd_sc_hd__a21bo_2 A1 A2 B1_N X
*.PININFO A1:I A2:I B1_N:I X:O
.ENDS

.SUBCKT sky130_fd_sc_hd__a21bo_4 A1 A2 B1_N X
*.PININFO A1:I A2:I B1_N:I X:O
.ENDS

.SUBCKT sky130_fd_sc_hd__a21boi_0 A1 A2 B1_N Y
*.PININFO A1:I A2:I B1_N:I Y:O
.ENDS

.SUBCKT sky130_fd_sc_hd__a21boi_1 A1 A2 B1_N Y
*.PININFO A1:I A2:I B1_N:I Y:O
.ENDS

.SUBCKT sky130_fd_sc_hd__a21boi_2 A1 A2 B1_N Y
*.PININFO A1:I A2:I B1_N:I Y:O
.ENDS

.SUBCKT sky130_fd_sc_hd__a21boi_4 A1 A2 B1_N Y
*.PININFO A1:I A2:I B1_N:I Y:O
.ENDS

.SUBCKT sky130_fd_sc_hd__a21o_1 A1 A2 B1 X
*.PININFO A1:I A2:I B1:I X:O
.ENDS

.SUBCKT sky130_fd_sc_hd__a21o_2 A1 A2 B1 X
*.PININFO A1:I A2:I B1:I X:O
.ENDS

.SUBCKT sky130_fd_sc_hd__a21o_4 A1 A2 B1 X
*.PININFO A1:I A2:I B1:I X:O
.ENDS

.SUBCKT sky130_fd_sc_hd__a21oi_1 A1 A2 B1 Y
*.PININFO A1:I A2:I B1:I Y:O
.ENDS

.SUBCKT sky130_fd_sc_hd__a21oi_2 A1 A2 B1 Y
*.PININFO A1:I A2:I B1:I Y:O
.ENDS

.SUBCKT sky130_fd_sc_hd__a21oi_4 A1 A2 B1 Y
*.PININFO A1:I A2:I B1:I Y:O
.ENDS

.SUBCKT sky130_fd_sc_hd__a221o_1 A1 A2 B1 B2 C1 X
*.PININFO A1:I A2:I B1:I B2:I C1:I X:O
.ENDS

.SUBCKT sky130_fd_sc_hd__a221o_2 A1 A2 B1 B2 C1 X
*.PININFO A1:I A2:I B1:I B2:I C1:I X:O
.ENDS

.SUBCKT sky130_fd_sc_hd__a221o_4 A1 A2 B1 B2 C1 X
*.PININFO A1:I A2:I B1:I B2:I C1:I X:O
.ENDS

.SUBCKT sky130_fd_sc_hd__a221oi_1 A1 A2 B1 B2 C1 Y
*.PININFO A1:I A2:I B1:I B2:I C1:I Y:O
.ENDS

.SUBCKT sky130_fd_sc_hd__a221oi_2 A1 A2 B1 B2 C1 Y
*.PININFO A1:I A2:I B1:I B2:I C1:I Y:O
.ENDS

.SUBCKT sky130_fd_sc_hd__a221oi_4 A1 A2 B1 B2 C1 Y
*.PININFO A1:I A2:I B1:I B2:I C1:I Y:O
.ENDS

.SUBCKT sky130_fd_sc_hd__a222oi_1 A1 A2 B1 B2 C1 C2 Y
*.PININFO A1:I A2:I B1:I B2:I C1:I C2:I Y:O
.ENDS

.SUBCKT sky130_fd_sc_hd__a22o_1 A1 A2 B1 B2 X
*.PININFO A1:I A2:I B1:I B2:I X:O
.ENDS

.SUBCKT sky130_fd_sc_hd__a22o_2 A1 A2 B1 B2 X
*.PININFO A1:I A2:I B1:I B2:I X:O
.ENDS

.SUBCKT sky130_fd_sc_hd__a22o_4 A1 A2 B1 B2 X
*.PININFO A1:I A2:I B1:I B2:I X:O
.ENDS

.SUBCKT sky130_fd_sc_hd__a22oi_1 A1 A2 B1 B2 Y
*.PININFO A1:I A2:I B1:I B2:I Y:O
.ENDS

.SUBCKT sky130_fd_sc_hd__a22oi_2 A1 A2 B1 B2 Y
*.PININFO A1:I A2:I B1:I B2:I Y:O
.ENDS

.SUBCKT sky130_fd_sc_hd__a22oi_4 A1 A2 B1 B2 Y
*.PININFO A1:I A2:I B1:I B2:I Y:O
.ENDS

.SUBCKT sky130_fd_sc_hd__a2bb2o_1 A1_N A2_N B1 B2 X
*.PININFO A1_N:I A2_N:I B1:I B2:I X:O
.ENDS

.SUBCKT sky130_fd_sc_hd__a2bb2o_2 A1_N A2_N B1 B2 X
*.PININFO A1_N:I A2_N:I B1:I B2:I X:O
.ENDS

.SUBCKT sky130_fd_sc_hd__a2bb2o_4 A1_N A2_N B1 B2 X
*.PININFO A1_N:I A2_N:I B1:I B2:I X:O
.ENDS

.SUBCKT sky130_fd_sc_hd__a2bb2oi_1 A1_N A2_N B1 B2 Y
*.PININFO A1_N:I A2_N:I B1:I B2:I Y:O
.ENDS

.SUBCKT sky130_fd_sc_hd__a2bb2oi_2 A1_N A2_N B1 B2 Y
*.PININFO A1_N:I A2_N:I B1:I B2:I Y:O
.ENDS

.SUBCKT sky130_fd_sc_hd__a2bb2oi_4 A1_N A2_N B1 B2 Y
*.PININFO A1_N:I A2_N:I B1:I B2:I Y:O
.ENDS

.SUBCKT sky130_fd_sc_hd__a311o_1 A1 A2 A3 B1 C1 X
*.PININFO A1:I A2:I A3:I B1:I C1:I X:O
.ENDS

.SUBCKT sky130_fd_sc_hd__a311o_2 A1 A2 A3 B1 C1 X
*.PININFO A1:I A2:I A3:I B1:I C1:I X:O
.ENDS

.SUBCKT sky130_fd_sc_hd__a311o_4 A1 A2 A3 B1 C1 X
*.PININFO A1:I A2:I A3:I B1:I C1:I X:O
.ENDS

.SUBCKT sky130_fd_sc_hd__a311oi_1 A1 A2 A3 B1 C1 Y
*.PININFO A1:I A2:I A3:I B1:I C1:I Y:O
.ENDS

.SUBCKT sky130_fd_sc_hd__a311oi_2 A1 A2 A3 B1 C1 Y
*.PININFO A1:I A2:I A3:I B1:I C1:I Y:O
.ENDS

.SUBCKT sky130_fd_sc_hd__a311oi_4 A1 A2 A3 B1 C1 Y
*.PININFO A1:I A2:I A3:I B1:I C1:I Y:O
.ENDS

.SUBCKT sky130_fd_sc_hd__a31o_1 A1 A2 A3 B1 X
*.PININFO A1:I A2:I A3:I B1:I X:O
.ENDS

.SUBCKT sky130_fd_sc_hd__a31o_2 A1 A2 A3 B1 X
*.PININFO A1:I A2:I A3:I B1:I X:O
.ENDS

.SUBCKT sky130_fd_sc_hd__a31o_4 A1 A2 A3 B1 X
*.PININFO A1:I A2:I A3:I B1:I X:O
.ENDS

.SUBCKT sky130_fd_sc_hd__a31oi_1 A1 A2 A3 B1 Y
*.PININFO A1:I A2:I A3:I B1:I Y:O
.ENDS

.SUBCKT sky130_fd_sc_hd__a31oi_2 A1 A2 A3 B1 Y
*.PININFO A1:I A2:I A3:I B1:I Y:O
.ENDS

.SUBCKT sky130_fd_sc_hd__a31oi_4 A1 A2 A3 B1 Y
*.PININFO A1:I A2:I A3:I B1:I Y:O
.ENDS

.SUBCKT sky130_fd_sc_hd__a32o_1 A1 A2 A3 B1 B2 X
*.PININFO A1:I A2:I A3:I B1:I B2:I X:O
.ENDS

.SUBCKT sky130_fd_sc_hd__a32o_2 A1 A2 A3 B1 B2 X
*.PININFO A1:I A2:I A3:I B1:I B2:I X:O
.ENDS

.SUBCKT sky130_fd_sc_hd__a32o_4 A1 A2 A3 B1 B2 X
*.PININFO A1:I A2:I A3:I B1:I B2:I X:O
.ENDS

.SUBCKT sky130_fd_sc_hd__a32oi_1 A1 A2 A3 B1 B2 Y
*.PININFO A1:I A2:I A3:I B1:I B2:I Y:O
.ENDS

.SUBCKT sky130_fd_sc_hd__a32oi_2 A1 A2 A3 B1 B2 Y
*.PININFO A1:I A2:I A3:I B1:I B2:I Y:O
.ENDS

.SUBCKT sky130_fd_sc_hd__a32oi_4 A1 A2 A3 B1 B2 Y
*.PININFO A1:I A2:I A3:I B1:I B2:I Y:O
.ENDS

.SUBCKT sky130_fd_sc_hd__a41o_1 A1 A2 A3 A4 B1 X
*.PININFO A1:I A2:I A3:I A4:I B1:I X:O
.ENDS

.SUBCKT sky130_fd_sc_hd__a41o_2 A1 A2 A3 A4 B1 X
*.PININFO A1:I A2:I A3:I A4:I B1:I X:O
.ENDS

.SUBCKT sky130_fd_sc_hd__a41o_4 A1 A2 A3 A4 B1 X
*.PININFO A1:I A2:I A3:I A4:I B1:I X:O
.ENDS

.SUBCKT sky130_fd_sc_hd__a41oi_1 A1 A2 A3 A4 B1 Y
*.PININFO A1:I A2:I A3:I A4:I B1:I Y:O
.ENDS

.SUBCKT sky130_fd_sc_hd__a41oi_2 A1 A2 A3 A4 B1 Y
*.PININFO A1:I A2:I A3:I A4:I B1:I Y:O
.ENDS

.SUBCKT sky130_fd_sc_hd__a41oi_4 A1 A2 A3 A4 B1 Y
*.PININFO A1:I A2:I A3:I A4:I B1:I Y:O
.ENDS

.SUBCKT sky130_fd_sc_hd__and2_0 A B X
*.PININFO A:I B:I X:O
.ENDS

.SUBCKT sky130_fd_sc_hd__and2_1 A B X
*.PININFO A:I B:I X:O
.ENDS

.SUBCKT sky130_fd_sc_hd__and2_2 A B X
*.PININFO A:I B:I X:O
.ENDS

.SUBCKT sky130_fd_sc_hd__and2_4 A B X
*.PININFO A:I B:I X:O
.ENDS

.SUBCKT sky130_fd_sc_hd__and2b_1 A_N B X
*.PININFO A_N:I B:I X:O
.ENDS

.SUBCKT sky130_fd_sc_hd__and2b_2 A_N B X
*.PININFO A_N:I B:I X:O
.ENDS

.SUBCKT sky130_fd_sc_hd__and2b_4 A_N B X
*.PININFO A_N:I B:I X:O
.ENDS

.SUBCKT sky130_fd_sc_hd__and3_1 A B C X
*.PININFO A:I B:I C:I X:O
.ENDS

.SUBCKT sky130_fd_sc_hd__and3_2 A B C X
*.PININFO A:I B:I C:I X:O
.ENDS

.SUBCKT sky130_fd_sc_hd__and3_4 A B C X
*.PININFO A:I B:I C:I X:O
.ENDS

.SUBCKT sky130_fd_sc_hd__and3b_1 A_N B C X
*.PININFO A_N:I B:I C:I X:O
.ENDS

.SUBCKT sky130_fd_sc_hd__and3b_2 A_N B C X
*.PININFO A_N:I B:I C:I X:O
.ENDS

.SUBCKT sky130_fd_sc_hd__and3b_4 A_N B C X
*.PININFO A_N:I B:I C:I X:O
.ENDS

.SUBCKT sky130_fd_sc_hd__and4_1 A B C D X
*.PININFO A:I B:I C:I D:I X:O
.ENDS

.SUBCKT sky130_fd_sc_hd__and4_2 A B C D X
*.PININFO A:I B:I C:I D:I X:O
.ENDS

.SUBCKT sky130_fd_sc_hd__and4_4 A B C D X
*.PININFO A:I B:I C:I D:I X:O
.ENDS

.SUBCKT sky130_fd_sc_hd__and4b_1 A_N B C D X
*.PININFO A_N:I B:I C:I D:I X:O
.ENDS

.SUBCKT sky130_fd_sc_hd__and4b_2 A_N B C D X
*.PININFO A_N:I B:I C:I D:I X:O
.ENDS

.SUBCKT sky130_fd_sc_hd__and4b_4 A_N B C D X
*.PININFO A_N:I B:I C:I D:I X:O
.ENDS

.SUBCKT sky130_fd_sc_hd__and4bb_1 A_N B_N C D X
*.PININFO A_N:I B_N:I C:I D:I X:O
.ENDS

.SUBCKT sky130_fd_sc_hd__and4bb_2 A_N B_N C D X
*.PININFO A_N:I B_N:I C:I D:I X:O
.ENDS

.SUBCKT sky130_fd_sc_hd__and4bb_4 A_N B_N C D X
*.PININFO A_N:I B_N:I C:I D:I X:O
.ENDS

.SUBCKT sky130_fd_sc_hd__buf_1 A X
*.PININFO A:I X:O
.ENDS

.SUBCKT sky130_fd_sc_hd__buf_12 A X
*.PININFO A:I X:O
.ENDS

.SUBCKT sky130_fd_sc_hd__buf_16 A X
*.PININFO A:I X:O
.ENDS

.SUBCKT sky130_fd_sc_hd__buf_2 A X
*.PININFO A:I X:O
.ENDS

.SUBCKT sky130_fd_sc_hd__buf_4 A X
*.PININFO A:I X:O
.ENDS

.SUBCKT sky130_fd_sc_hd__buf_6 A X
*.PININFO A:I X:O
.ENDS

.SUBCKT sky130_fd_sc_hd__buf_8 A X
*.PININFO A:I X:O
.ENDS

.SUBCKT sky130_fd_sc_hd__bufbuf_16 A X
*.PININFO A:I X:O
.ENDS

.SUBCKT sky130_fd_sc_hd__bufbuf_8 A X
*.PININFO A:I X:O
.ENDS

.SUBCKT sky130_fd_sc_hd__bufinv_16 A Y
*.PININFO A:I Y:O
.ENDS

.SUBCKT sky130_fd_sc_hd__bufinv_8 A Y
*.PININFO A:I Y:O
.ENDS

.SUBCKT sky130_fd_sc_hd__clkbuf_1 A X
*.PININFO A:I X:O
.ENDS

.SUBCKT sky130_fd_sc_hd__clkbuf_16 A X
*.PININFO A:I X:O
.ENDS

.SUBCKT sky130_fd_sc_hd__clkbuf_2 A X
*.PININFO A:I X:O
.ENDS

.SUBCKT sky130_fd_sc_hd__clkbuf_4 A X
*.PININFO A:I X:O
.ENDS

.SUBCKT sky130_fd_sc_hd__clkbuf_8 A X
*.PININFO A:I X:O
.ENDS

.SUBCKT sky130_fd_sc_hd__clkdlybuf4s15_1 A X
*.PININFO A:I X:O
.ENDS

.SUBCKT sky130_fd_sc_hd__clkdlybuf4s15_2 A X
*.PININFO A:I X:O
.ENDS

.SUBCKT sky130_fd_sc_hd__clkdlybuf4s18_1 A X
*.PININFO A:I X:O
.ENDS

.SUBCKT sky130_fd_sc_hd__clkdlybuf4s18_2 A X
*.PININFO A:I X:O
.ENDS

.SUBCKT sky130_fd_sc_hd__clkdlybuf4s25_1 A X
*.PININFO A:I X:O
.ENDS

.SUBCKT sky130_fd_sc_hd__clkdlybuf4s25_2 A X
*.PININFO A:I X:O
.ENDS

.SUBCKT sky130_fd_sc_hd__clkdlybuf4s50_1 A X
*.PININFO A:I X:O
.ENDS

.SUBCKT sky130_fd_sc_hd__clkdlybuf4s50_2 A X
*.PININFO A:I X:O
.ENDS

.SUBCKT sky130_fd_sc_hd__clkinv_1 A Y
*.PININFO A:I Y:O
.ENDS

.SUBCKT sky130_fd_sc_hd__clkinv_16 A Y
*.PININFO A:I Y:O
.ENDS

.SUBCKT sky130_fd_sc_hd__clkinv_2 A Y
*.PININFO A:I Y:O
.ENDS

.SUBCKT sky130_fd_sc_hd__clkinv_4 A Y
*.PININFO A:I Y:O
.ENDS

.SUBCKT sky130_fd_sc_hd__clkinv_8 A Y
*.PININFO A:I Y:O
.ENDS

.SUBCKT sky130_fd_sc_hd__clkinvlp_2 A Y
*.PININFO A:I Y:O
.ENDS

.SUBCKT sky130_fd_sc_hd__clkinvlp_4 A Y
*.PININFO A:I Y:O
.ENDS

.SUBCKT sky130_fd_sc_hd__conb_1 HI LO
*.PININFO HI:O LO:O
.ENDS

.SUBCKT sky130_fd_sc_hd__dfbbn_1 CLK_N D Q Q_N RESET_B SET_B
*.PININFO CLK_N:I D:I Q:O Q_N:O RESET_B:I SET_B:I
.ENDS

.SUBCKT sky130_fd_sc_hd__dfbbn_2 CLK_N D Q Q_N RESET_B SET_B
*.PININFO CLK_N:I D:I Q:O Q_N:O RESET_B:I SET_B:I
.ENDS

.SUBCKT sky130_fd_sc_hd__dfbbp_1 CLK D Q Q_N RESET_B SET_B
*.PININFO CLK:I D:I Q:O Q_N:O RESET_B:I SET_B:I
.ENDS

.SUBCKT sky130_fd_sc_hd__dfrbp_1 CLK D Q Q_N RESET_B
*.PININFO CLK:I D:I Q:O Q_N:O RESET_B:I
.ENDS

.SUBCKT sky130_fd_sc_hd__dfrbp_2 CLK D Q Q_N RESET_B
*.PININFO CLK:I D:I Q:O Q_N:O RESET_B:I
.ENDS

.SUBCKT sky130_fd_sc_hd__dfrtn_1 CLK_N D Q RESET_B
*.PININFO CLK_N:I D:I Q:O RESET_B:I
.ENDS

.SUBCKT sky130_fd_sc_hd__dfrtp_1 CLK D Q RESET_B
*.PININFO CLK:I D:I Q:O RESET_B:I
.ENDS

.SUBCKT sky130_fd_sc_hd__dfrtp_2 CLK D Q RESET_B
*.PININFO CLK:I D:I Q:O RESET_B:I
.ENDS

.SUBCKT sky130_fd_sc_hd__dfrtp_4 CLK D Q RESET_B
*.PININFO CLK:I D:I Q:O RESET_B:I
.ENDS

.SUBCKT sky130_fd_sc_hd__dfsbp_1 CLK D Q Q_N SET_B
*.PININFO CLK:I D:I Q:O Q_N:O SET_B:I
.ENDS

.SUBCKT sky130_fd_sc_hd__dfsbp_2 CLK D Q Q_N SET_B
*.PININFO CLK:I D:I Q:O Q_N:O SET_B:I
.ENDS

.SUBCKT sky130_fd_sc_hd__dfstp_1 CLK D Q SET_B
*.PININFO CLK:I D:I Q:O SET_B:I
.ENDS

.SUBCKT sky130_fd_sc_hd__dfstp_2 CLK D Q SET_B
*.PININFO CLK:I D:I Q:O SET_B:I
.ENDS

.SUBCKT sky130_fd_sc_hd__dfstp_4 CLK D Q SET_B
*.PININFO CLK:I D:I Q:O SET_B:I
.ENDS

.SUBCKT sky130_fd_sc_hd__dfxbp_1 CLK D Q Q_N
*.PININFO CLK:I D:I Q:O Q_N:O
.ENDS

.SUBCKT sky130_fd_sc_hd__dfxbp_2 CLK D Q Q_N
*.PININFO CLK:I D:I Q:O Q_N:O
.ENDS

.SUBCKT sky130_fd_sc_hd__dfxtp_1 CLK D Q
*.PININFO CLK:I D:I Q:O
.ENDS

.SUBCKT sky130_fd_sc_hd__dfxtp_2 CLK D Q
*.PININFO CLK:I D:I Q:O
.ENDS

.SUBCKT sky130_fd_sc_hd__dfxtp_4 CLK D Q
*.PININFO CLK:I D:I Q:O
.ENDS

.SUBCKT sky130_fd_sc_hd__diode_2 DIODE
*.PININFO DIODE:I
.ENDS

.SUBCKT sky130_fd_sc_hd__dlclkp_1 CLK GATE GCLK M0
*.PININFO CLK:I GATE:I GCLK:O M0:B
.ENDS

.SUBCKT sky130_fd_sc_hd__dlclkp_2 CLK GATE GCLK M0
*.PININFO CLK:I GATE:I GCLK:O M0:B
.ENDS

.SUBCKT sky130_fd_sc_hd__dlclkp_4 CLK GATE GCLK M0
*.PININFO CLK:I GATE:I GCLK:O M0:B
.ENDS

.SUBCKT sky130_fd_sc_hd__dlrbn_1 D GATE_N Q Q_N RESET_B
*.PININFO D:I GATE_N:I Q:O Q_N:O RESET_B:I
.ENDS

.SUBCKT sky130_fd_sc_hd__dlrbn_2 D GATE_N Q Q_N RESET_B
*.PININFO D:I GATE_N:I Q:O Q_N:O RESET_B:I
.ENDS

.SUBCKT sky130_fd_sc_hd__dlrbp_1 D GATE Q Q_N RESET_B
*.PININFO D:I GATE:I Q:O Q_N:O RESET_B:I
.ENDS

.SUBCKT sky130_fd_sc_hd__dlrbp_2 D GATE Q Q_N RESET_B
*.PININFO D:I GATE:I Q:O Q_N:O RESET_B:I
.ENDS

.SUBCKT sky130_fd_sc_hd__dlrtn_1 D GATE_N Q RESET_B
*.PININFO D:I GATE_N:I Q:O RESET_B:I
.ENDS

.SUBCKT sky130_fd_sc_hd__dlrtn_2 D GATE_N Q RESET_B
*.PININFO D:I GATE_N:I Q:O RESET_B:I
.ENDS

.SUBCKT sky130_fd_sc_hd__dlrtn_4 D GATE_N Q RESET_B
*.PININFO D:I GATE_N:I Q:O RESET_B:I
.ENDS

.SUBCKT sky130_fd_sc_hd__dlrtp_1 D GATE Q RESET_B
*.PININFO D:I GATE:I Q:O RESET_B:I
.ENDS

.SUBCKT sky130_fd_sc_hd__dlrtp_2 D GATE Q RESET_B
*.PININFO D:I GATE:I Q:O RESET_B:I
.ENDS

.SUBCKT sky130_fd_sc_hd__dlrtp_4 D GATE Q RESET_B
*.PININFO D:I GATE:I Q:O RESET_B:I
.ENDS

.SUBCKT sky130_fd_sc_hd__dlxbn_1 D GATE_N Q Q_N
*.PININFO D:I GATE_N:I Q:O Q_N:O
.ENDS

.SUBCKT sky130_fd_sc_hd__dlxbn_2 D GATE_N Q Q_N
*.PININFO D:I GATE_N:I Q:O Q_N:O
.ENDS

.SUBCKT sky130_fd_sc_hd__dlxbp_1 D GATE Q Q_N
*.PININFO D:I GATE:I Q:O Q_N:O
.ENDS

.SUBCKT sky130_fd_sc_hd__dlxtn_1 D GATE_N Q
*.PININFO D:I GATE_N:I Q:O
.ENDS

.SUBCKT sky130_fd_sc_hd__dlxtn_2 D GATE_N Q
*.PININFO D:I GATE_N:I Q:O
.ENDS

.SUBCKT sky130_fd_sc_hd__dlxtn_4 D GATE_N Q
*.PININFO D:I GATE_N:I Q:O
.ENDS

.SUBCKT sky130_fd_sc_hd__dlxtp_1 D GATE Q
*.PININFO D:I GATE:I Q:O
.ENDS

.SUBCKT sky130_fd_sc_hd__dlygate4sd1_1 A X
*.PININFO A:I X:O
.ENDS

.SUBCKT sky130_fd_sc_hd__dlygate4sd2_1 A X
*.PININFO A:I X:O
.ENDS

.SUBCKT sky130_fd_sc_hd__dlygate4sd3_1 A X
*.PININFO A:I X:O
.ENDS

.SUBCKT sky130_fd_sc_hd__dlymetal6s2s_1 A X
*.PININFO A:I X:O
.ENDS

.SUBCKT sky130_fd_sc_hd__dlymetal6s4s_1 A X
*.PININFO A:I X:O
.ENDS

.SUBCKT sky130_fd_sc_hd__dlymetal6s6s_1 A X
*.PININFO A:I X:O
.ENDS

.SUBCKT sky130_fd_sc_hd__ebufn_1 A TE_B Z
*.PININFO A:I TE_B:I Z:O
.ENDS

.SUBCKT sky130_fd_sc_hd__ebufn_2 A TE_B Z
*.PININFO A:I TE_B:I Z:O
.ENDS

.SUBCKT sky130_fd_sc_hd__ebufn_4 A TE_B Z
*.PININFO A:I TE_B:I Z:O
.ENDS

.SUBCKT sky130_fd_sc_hd__ebufn_8 A TE_B Z
*.PININFO A:I TE_B:I Z:O
.ENDS

.SUBCKT sky130_fd_sc_hd__edfxbp_1 CLK D DE Q Q_N
*.PININFO CLK:I D:I DE:I Q:O Q_N:O
.ENDS

.SUBCKT sky130_fd_sc_hd__edfxtp_1 CLK D DE Q
*.PININFO CLK:I D:I DE:I Q:O
.ENDS

.SUBCKT sky130_fd_sc_hd__einvn_0 A TE_B Z
*.PININFO A:I TE_B:I Z:O
.ENDS

.SUBCKT sky130_fd_sc_hd__einvn_1 A TE_B Z
*.PININFO A:I TE_B:I Z:O
.ENDS

.SUBCKT sky130_fd_sc_hd__einvn_2 A TE_B Z
*.PININFO A:I TE_B:I Z:O
.ENDS

.SUBCKT sky130_fd_sc_hd__einvn_4 A TE_B Z
*.PININFO A:I TE_B:I Z:O
.ENDS

.SUBCKT sky130_fd_sc_hd__einvn_8 A TE_B Z
*.PININFO A:I TE_B:I Z:O
.ENDS

.SUBCKT sky130_fd_sc_hd__einvp_1 A TE Z
*.PININFO A:I TE:I Z:O
.ENDS

.SUBCKT sky130_fd_sc_hd__einvp_2 A TE Z
*.PININFO A:I TE:I Z:O
.ENDS

.SUBCKT sky130_fd_sc_hd__einvp_4 A TE Z
*.PININFO A:I TE:I Z:O
.ENDS

.SUBCKT sky130_fd_sc_hd__einvp_8 A TE Z
*.PININFO A:I TE:I Z:O
.ENDS

.SUBCKT sky130_fd_sc_hd__fa_1 A B CIN COUT SUM
*.PININFO A:I B:I CIN:I COUT:O SUM:O
.ENDS

.SUBCKT sky130_fd_sc_hd__fa_2 A B CIN COUT SUM
*.PININFO A:I B:I CIN:I COUT:O SUM:O
.ENDS

.SUBCKT sky130_fd_sc_hd__fa_4 A B CIN COUT SUM
*.PININFO A:I B:I CIN:I COUT:O SUM:O
.ENDS

.SUBCKT sky130_fd_sc_hd__fah_1 A B CI COUT SUM
*.PININFO A:I B:I CI:I COUT:O SUM:O
.ENDS

.SUBCKT sky130_fd_sc_hd__fahcin_1 A B CIN COUT SUM
*.PININFO A:I B:I CIN:I COUT:O SUM:O
.ENDS

.SUBCKT sky130_fd_sc_hd__fahcon_1 A B CI COUT_N SUM
*.PININFO A:I B:I CI:I COUT_N:O SUM:O
.ENDS

.SUBCKT sky130_fd_sc_hd__ha_1 A B COUT SUM
*.PININFO A:I B:I COUT:O SUM:O
.ENDS

.SUBCKT sky130_fd_sc_hd__ha_2 A B COUT SUM
*.PININFO A:I B:I COUT:O SUM:O
.ENDS

.SUBCKT sky130_fd_sc_hd__ha_4 A B COUT SUM
*.PININFO A:I B:I COUT:O SUM:O
.ENDS

.SUBCKT sky130_fd_sc_hd__inv_1 A Y
*.PININFO A:I Y:O
.ENDS

.SUBCKT sky130_fd_sc_hd__inv_12 A Y
*.PININFO A:I Y:O
.ENDS

.SUBCKT sky130_fd_sc_hd__inv_16 A Y
*.PININFO A:I Y:O
.ENDS

.SUBCKT sky130_fd_sc_hd__inv_2 A Y
*.PININFO A:I Y:O
.ENDS

.SUBCKT sky130_fd_sc_hd__inv_4 A Y
*.PININFO A:I Y:O
.ENDS

.SUBCKT sky130_fd_sc_hd__inv_6 A Y
*.PININFO A:I Y:O
.ENDS

.SUBCKT sky130_fd_sc_hd__inv_8 A Y
*.PININFO A:I Y:O
.ENDS

.SUBCKT sky130_fd_sc_hd__lpflow_bleeder_1 SHORT
*.PININFO SHORT:I
.ENDS

.SUBCKT sky130_fd_sc_hd__lpflow_clkbufkapwr_1 A X
*.PININFO A:I X:O
.ENDS

.SUBCKT sky130_fd_sc_hd__lpflow_clkbufkapwr_16 A X
*.PININFO A:I X:O
.ENDS

.SUBCKT sky130_fd_sc_hd__lpflow_clkbufkapwr_2 A X
*.PININFO A:I X:O
.ENDS

.SUBCKT sky130_fd_sc_hd__lpflow_clkbufkapwr_4 A X
*.PININFO A:I X:O
.ENDS

.SUBCKT sky130_fd_sc_hd__lpflow_clkbufkapwr_8 A X
*.PININFO A:I X:O
.ENDS

.SUBCKT sky130_fd_sc_hd__lpflow_clkinvkapwr_1 A Y
*.PININFO A:I Y:O
.ENDS

.SUBCKT sky130_fd_sc_hd__lpflow_clkinvkapwr_16 A Y
*.PININFO A:I Y:O
.ENDS

.SUBCKT sky130_fd_sc_hd__lpflow_clkinvkapwr_2 A Y
*.PININFO A:I Y:O
.ENDS

.SUBCKT sky130_fd_sc_hd__lpflow_clkinvkapwr_4 A Y
*.PININFO A:I Y:O
.ENDS

.SUBCKT sky130_fd_sc_hd__lpflow_clkinvkapwr_8 A Y
*.PININFO A:I Y:O
.ENDS

.SUBCKT sky130_fd_sc_hd__lpflow_inputiso0n_1 A SLEEP_B X
*.PININFO A:I SLEEP_B:I X:O
.ENDS

.SUBCKT sky130_fd_sc_hd__lpflow_inputiso0p_1 A SLEEP X
*.PININFO A:I SLEEP:I X:O
.ENDS

.SUBCKT sky130_fd_sc_hd__lpflow_inputiso1n_1 A SLEEP_B X
*.PININFO A:I SLEEP_B:I X:O
.ENDS

.SUBCKT sky130_fd_sc_hd__lpflow_inputiso1p_1 A SLEEP X
*.PININFO A:I SLEEP:I X:O
.ENDS

.SUBCKT sky130_fd_sc_hd__lpflow_inputisolatch_1 D Q SLEEP_B
*.PININFO D:I Q:O SLEEP_B:I
.ENDS

.SUBCKT sky130_fd_sc_hd__lpflow_isobufsrc_1 A SLEEP X
*.PININFO A:I SLEEP:I X:O
.ENDS

.SUBCKT sky130_fd_sc_hd__lpflow_isobufsrc_16 A SLEEP X
*.PININFO A:I SLEEP:I X:O
.ENDS

.SUBCKT sky130_fd_sc_hd__lpflow_isobufsrc_2 A SLEEP X
*.PININFO A:I SLEEP:I X:O
.ENDS

.SUBCKT sky130_fd_sc_hd__lpflow_isobufsrc_4 A SLEEP X
*.PININFO A:I SLEEP:I X:O
.ENDS

.SUBCKT sky130_fd_sc_hd__lpflow_isobufsrc_8 A SLEEP X
*.PININFO A:I SLEEP:I X:O
.ENDS

.SUBCKT sky130_fd_sc_hd__lpflow_isobufsrckapwr_16 A SLEEP X
*.PININFO A:I SLEEP:I X:O
.ENDS

.SUBCKT sky130_fd_sc_hd__lpflow_lsbuf_lh_hl_isowell_tap_1 A X
*.PININFO A:I X:O
.ENDS

.SUBCKT sky130_fd_sc_hd__lpflow_lsbuf_lh_hl_isowell_tap_2 A X
*.PININFO A:I X:O
.ENDS

.SUBCKT sky130_fd_sc_hd__lpflow_lsbuf_lh_hl_isowell_tap_4 A X
*.PININFO A:I X:O
.ENDS

.SUBCKT sky130_fd_sc_hd__lpflow_lsbuf_lh_isowell_4 A X
*.PININFO A:I X:O
.ENDS

.SUBCKT sky130_fd_sc_hd__lpflow_lsbuf_lh_isowell_tap_1 A X
*.PININFO A:I X:O
.ENDS

.SUBCKT sky130_fd_sc_hd__lpflow_lsbuf_lh_isowell_tap_2 A X
*.PININFO A:I X:O
.ENDS

.SUBCKT sky130_fd_sc_hd__lpflow_lsbuf_lh_isowell_tap_4 A X
*.PININFO A:I X:O
.ENDS

.SUBCKT sky130_fd_sc_hd__macro_sparecell LO
*.PININFO LO:O
.ENDS

.SUBCKT sky130_fd_sc_hd__maj3_1 A B C X
*.PININFO A:I B:I C:I X:O
.ENDS

.SUBCKT sky130_fd_sc_hd__maj3_2 A B C X
*.PININFO A:I B:I C:I X:O
.ENDS

.SUBCKT sky130_fd_sc_hd__maj3_4 A B C X
*.PININFO A:I B:I C:I X:O
.ENDS

.SUBCKT sky130_fd_sc_hd__mux2_1 A0 A1 S X
*.PININFO A0:I A1:I S:I X:O
.ENDS

.SUBCKT sky130_fd_sc_hd__mux2_2 A0 A1 S X
*.PININFO A0:I A1:I S:I X:O
.ENDS

.SUBCKT sky130_fd_sc_hd__mux2_4 A0 A1 S X
*.PININFO A0:I A1:I S:I X:O
.ENDS

.SUBCKT sky130_fd_sc_hd__mux2_8 A0 A1 S X
*.PININFO A0:I A1:I S:I X:O
.ENDS

.SUBCKT sky130_fd_sc_hd__mux2i_1 A0 A1 S Y
*.PININFO A0:I A1:I S:I Y:O
.ENDS

.SUBCKT sky130_fd_sc_hd__mux2i_2 A0 A1 S Y
*.PININFO A0:I A1:I S:I Y:O
.ENDS

.SUBCKT sky130_fd_sc_hd__mux2i_4 A0 A1 S Y
*.PININFO A0:I A1:I S:I Y:O
.ENDS

.SUBCKT sky130_fd_sc_hd__mux4_1 A0 A1 A2 A3 S0 S1 X
*.PININFO A0:I A1:I A2:I A3:I S0:I S1:I X:O
.ENDS

.SUBCKT sky130_fd_sc_hd__mux4_2 A0 A1 A2 A3 S0 S1 X
*.PININFO A0:I A1:I A2:I A3:I S0:I S1:I X:O
.ENDS

.SUBCKT sky130_fd_sc_hd__mux4_4 A0 A1 A2 A3 S0 S1 X
*.PININFO A0:I A1:I A2:I A3:I S0:I S1:I X:O
.ENDS

.SUBCKT sky130_fd_sc_hd__nand2_1 A B Y
*.PININFO A:I B:I Y:O
.ENDS

.SUBCKT sky130_fd_sc_hd__nand2_2 A B Y
*.PININFO A:I B:I Y:O
.ENDS

.SUBCKT sky130_fd_sc_hd__nand2_4 A B Y
*.PININFO A:I B:I Y:O
.ENDS

.SUBCKT sky130_fd_sc_hd__nand2_8 A B Y
*.PININFO A:I B:I Y:O
.ENDS

.SUBCKT sky130_fd_sc_hd__nand2b_1 A_N B Y
*.PININFO A_N:I B:I Y:O
.ENDS

.SUBCKT sky130_fd_sc_hd__nand2b_2 A_N B Y
*.PININFO A_N:I B:I Y:O
.ENDS

.SUBCKT sky130_fd_sc_hd__nand2b_4 A_N B Y
*.PININFO A_N:I B:I Y:O
.ENDS

.SUBCKT sky130_fd_sc_hd__nand3_1 A B C Y
*.PININFO A:I B:I C:I Y:O
.ENDS

.SUBCKT sky130_fd_sc_hd__nand3_2 A B C Y
*.PININFO A:I B:I C:I Y:O
.ENDS

.SUBCKT sky130_fd_sc_hd__nand3_4 A B C Y
*.PININFO A:I B:I C:I Y:O
.ENDS

.SUBCKT sky130_fd_sc_hd__nand3b_1 A_N B C Y
*.PININFO A_N:I B:I C:I Y:O
.ENDS

.SUBCKT sky130_fd_sc_hd__nand3b_2 A_N B C Y
*.PININFO A_N:I B:I C:I Y:O
.ENDS

.SUBCKT sky130_fd_sc_hd__nand3b_4 A_N B C Y
*.PININFO A_N:I B:I C:I Y:O
.ENDS

.SUBCKT sky130_fd_sc_hd__nand4_1 A B C D Y
*.PININFO A:I B:I C:I D:I Y:O
.ENDS

.SUBCKT sky130_fd_sc_hd__nand4_2 A B C D Y
*.PININFO A:I B:I C:I D:I Y:O
.ENDS

.SUBCKT sky130_fd_sc_hd__nand4_4 A B C D Y
*.PININFO A:I B:I C:I D:I Y:O
.ENDS

.SUBCKT sky130_fd_sc_hd__nand4b_1 A_N B C D Y
*.PININFO A_N:I B:I C:I D:I Y:O
.ENDS

.SUBCKT sky130_fd_sc_hd__nand4b_2 A_N B C D Y
*.PININFO A_N:I B:I C:I D:I Y:O
.ENDS

.SUBCKT sky130_fd_sc_hd__nand4b_4 A_N B C D Y
*.PININFO A_N:I B:I C:I D:I Y:O
.ENDS

.SUBCKT sky130_fd_sc_hd__nand4bb_1 A_N B_N C D Y
*.PININFO A_N:I B_N:I C:I D:I Y:O
.ENDS

.SUBCKT sky130_fd_sc_hd__nand4bb_2 A_N B_N C D Y
*.PININFO A_N:I B_N:I C:I D:I Y:O
.ENDS

.SUBCKT sky130_fd_sc_hd__nand4bb_4 A_N B_N C D Y
*.PININFO A_N:I B_N:I C:I D:I Y:O
.ENDS

.SUBCKT sky130_fd_sc_hd__nor2_1 A B Y
*.PININFO A:I B:I Y:O
.ENDS

.SUBCKT sky130_fd_sc_hd__nor2_2 A B Y
*.PININFO A:I B:I Y:O
.ENDS

.SUBCKT sky130_fd_sc_hd__nor2_4 A B Y
*.PININFO A:I B:I Y:O
.ENDS

.SUBCKT sky130_fd_sc_hd__nor2_8 A B Y
*.PININFO A:I B:I Y:O
.ENDS

.SUBCKT sky130_fd_sc_hd__nor2b_1 A B_N Y
*.PININFO A:I B_N:I Y:O
.ENDS

.SUBCKT sky130_fd_sc_hd__nor2b_2 A B_N Y
*.PININFO A:I B_N:I Y:O
.ENDS

.SUBCKT sky130_fd_sc_hd__nor2b_4 A B_N Y
*.PININFO A:I B_N:I Y:O
.ENDS

.SUBCKT sky130_fd_sc_hd__nor3_1 A B C Y
*.PININFO A:I B:I C:I Y:O
.ENDS

.SUBCKT sky130_fd_sc_hd__nor3_2 A B C Y
*.PININFO A:I B:I C:I Y:O
.ENDS

.SUBCKT sky130_fd_sc_hd__nor3_4 A B C Y
*.PININFO A:I B:I C:I Y:O
.ENDS

.SUBCKT sky130_fd_sc_hd__nor3b_1 A B C_N Y
*.PININFO A:I B:I C_N:I Y:O
.ENDS

.SUBCKT sky130_fd_sc_hd__nor3b_2 A B C_N Y
*.PININFO A:I B:I C_N:I Y:O
.ENDS

.SUBCKT sky130_fd_sc_hd__nor3b_4 A B C_N Y
*.PININFO A:I B:I C_N:I Y:O
.ENDS

.SUBCKT sky130_fd_sc_hd__nor4_1 A B C D Y
*.PININFO A:I B:I C:I D:I Y:O
.ENDS

.SUBCKT sky130_fd_sc_hd__nor4_2 A B C D Y
*.PININFO A:I B:I C:I D:I Y:O
.ENDS

.SUBCKT sky130_fd_sc_hd__nor4_4 A B C D Y
*.PININFO A:I B:I C:I D:I Y:O
.ENDS

.SUBCKT sky130_fd_sc_hd__nor4b_1 A B C D_N Y
*.PININFO A:I B:I C:I D_N:I Y:O
.ENDS

.SUBCKT sky130_fd_sc_hd__nor4b_2 A B C D_N Y
*.PININFO A:I B:I C:I D_N:I Y:O
.ENDS

.SUBCKT sky130_fd_sc_hd__nor4b_4 A B C D_N Y
*.PININFO A:I B:I C:I D_N:I Y:O
.ENDS

.SUBCKT sky130_fd_sc_hd__nor4bb_1 A B C_N D_N Y
*.PININFO A:I B:I C_N:I D_N:I Y:O
.ENDS

.SUBCKT sky130_fd_sc_hd__nor4bb_2 A B C_N D_N Y
*.PININFO A:I B:I C_N:I D_N:I Y:O
.ENDS

.SUBCKT sky130_fd_sc_hd__nor4bb_4 A B C_N D_N Y
*.PININFO A:I B:I C_N:I D_N:I Y:O
.ENDS

.SUBCKT sky130_fd_sc_hd__o2111a_1 A1 A2 B1 C1 D1 X
*.PININFO A1:I A2:I B1:I C1:I D1:I X:O
.ENDS

.SUBCKT sky130_fd_sc_hd__o2111a_2 A1 A2 B1 C1 D1 X
*.PININFO A1:I A2:I B1:I C1:I D1:I X:O
.ENDS

.SUBCKT sky130_fd_sc_hd__o2111a_4 A1 A2 B1 C1 D1 X
*.PININFO A1:I A2:I B1:I C1:I D1:I X:O
.ENDS

.SUBCKT sky130_fd_sc_hd__o2111ai_1 A1 A2 B1 C1 D1 Y
*.PININFO A1:I A2:I B1:I C1:I D1:I Y:O
.ENDS

.SUBCKT sky130_fd_sc_hd__o2111ai_2 A1 A2 B1 C1 D1 Y
*.PININFO A1:I A2:I B1:I C1:I D1:I Y:O
.ENDS

.SUBCKT sky130_fd_sc_hd__o2111ai_4 A1 A2 B1 C1 D1 Y
*.PININFO A1:I A2:I B1:I C1:I D1:I Y:O
.ENDS

.SUBCKT sky130_fd_sc_hd__o211a_1 A1 A2 B1 C1 X
*.PININFO A1:I A2:I B1:I C1:I X:O
.ENDS

.SUBCKT sky130_fd_sc_hd__o211a_2 A1 A2 B1 C1 X
*.PININFO A1:I A2:I B1:I C1:I X:O
.ENDS

.SUBCKT sky130_fd_sc_hd__o211a_4 A1 A2 B1 C1 X
*.PININFO A1:I A2:I B1:I C1:I X:O
.ENDS

.SUBCKT sky130_fd_sc_hd__o211ai_1 A1 A2 B1 C1 Y
*.PININFO A1:I A2:I B1:I C1:I Y:O
.ENDS

.SUBCKT sky130_fd_sc_hd__o211ai_2 A1 A2 B1 C1 Y
*.PININFO A1:I A2:I B1:I C1:I Y:O
.ENDS

.SUBCKT sky130_fd_sc_hd__o211ai_4 A1 A2 B1 C1 Y
*.PININFO A1:I A2:I B1:I C1:I Y:O
.ENDS

.SUBCKT sky130_fd_sc_hd__o21a_1 A1 A2 B1 X
*.PININFO A1:I A2:I B1:I X:O
.ENDS

.SUBCKT sky130_fd_sc_hd__o21a_2 A1 A2 B1 X
*.PININFO A1:I A2:I B1:I X:O
.ENDS

.SUBCKT sky130_fd_sc_hd__o21a_4 A1 A2 B1 X
*.PININFO A1:I A2:I B1:I X:O
.ENDS

.SUBCKT sky130_fd_sc_hd__o21ai_0 A1 A2 B1 Y
*.PININFO A1:I A2:I B1:I Y:O
.ENDS

.SUBCKT sky130_fd_sc_hd__o21ai_1 A1 A2 B1 Y
*.PININFO A1:I A2:I B1:I Y:O
.ENDS

.SUBCKT sky130_fd_sc_hd__o21ai_2 A1 A2 B1 Y
*.PININFO A1:I A2:I B1:I Y:O
.ENDS

.SUBCKT sky130_fd_sc_hd__o21ai_4 A1 A2 B1 Y
*.PININFO A1:I A2:I B1:I Y:O
.ENDS

.SUBCKT sky130_fd_sc_hd__o21ba_1 A1 A2 B1_N X
*.PININFO A1:I A2:I B1_N:I X:O
.ENDS

.SUBCKT sky130_fd_sc_hd__o21ba_2 A1 A2 B1_N X
*.PININFO A1:I A2:I B1_N:I X:O
.ENDS

.SUBCKT sky130_fd_sc_hd__o21ba_4 A1 A2 B1_N X
*.PININFO A1:I A2:I B1_N:I X:O
.ENDS

.SUBCKT sky130_fd_sc_hd__o21bai_1 A1 A2 B1_N Y
*.PININFO A1:I A2:I B1_N:I Y:O
.ENDS

.SUBCKT sky130_fd_sc_hd__o21bai_2 A1 A2 B1_N Y
*.PININFO A1:I A2:I B1_N:I Y:O
.ENDS

.SUBCKT sky130_fd_sc_hd__o21bai_4 A1 A2 B1_N Y
*.PININFO A1:I A2:I B1_N:I Y:O
.ENDS

.SUBCKT sky130_fd_sc_hd__o221a_1 A1 A2 B1 B2 C1 X
*.PININFO A1:I A2:I B1:I B2:I C1:I X:O
.ENDS

.SUBCKT sky130_fd_sc_hd__o221a_2 A1 A2 B1 B2 C1 X
*.PININFO A1:I A2:I B1:I B2:I C1:I X:O
.ENDS

.SUBCKT sky130_fd_sc_hd__o221a_4 A1 A2 B1 B2 C1 X
*.PININFO A1:I A2:I B1:I B2:I C1:I X:O
.ENDS

.SUBCKT sky130_fd_sc_hd__o221ai_1 A1 A2 B1 B2 C1 Y
*.PININFO A1:I A2:I B1:I B2:I C1:I Y:O
.ENDS

.SUBCKT sky130_fd_sc_hd__o221ai_2 A1 A2 B1 B2 C1 Y
*.PININFO A1:I A2:I B1:I B2:I C1:I Y:O
.ENDS

.SUBCKT sky130_fd_sc_hd__o221ai_4 A1 A2 B1 B2 C1 Y
*.PININFO A1:I A2:I B1:I B2:I C1:I Y:O
.ENDS

.SUBCKT sky130_fd_sc_hd__o22a_1 A1 A2 B1 B2 X
*.PININFO A1:I A2:I B1:I B2:I X:O
.ENDS

.SUBCKT sky130_fd_sc_hd__o22a_2 A1 A2 B1 B2 X
*.PININFO A1:I A2:I B1:I B2:I X:O
.ENDS

.SUBCKT sky130_fd_sc_hd__o22a_4 A1 A2 B1 B2 X
*.PININFO A1:I A2:I B1:I B2:I X:O
.ENDS

.SUBCKT sky130_fd_sc_hd__o22ai_1 A1 A2 B1 B2 Y
*.PININFO A1:I A2:I B1:I B2:I Y:O
.ENDS

.SUBCKT sky130_fd_sc_hd__o22ai_2 A1 A2 B1 B2 Y
*.PININFO A1:I A2:I B1:I B2:I Y:O
.ENDS

.SUBCKT sky130_fd_sc_hd__o22ai_4 A1 A2 B1 B2 Y
*.PININFO A1:I A2:I B1:I B2:I Y:O
.ENDS

.SUBCKT sky130_fd_sc_hd__o2bb2a_1 A1_N A2_N B1 B2 X
*.PININFO A1_N:I A2_N:I B1:I B2:I X:O
.ENDS

.SUBCKT sky130_fd_sc_hd__o2bb2a_2 A1_N A2_N B1 B2 X
*.PININFO A1_N:I A2_N:I B1:I B2:I X:O
.ENDS

.SUBCKT sky130_fd_sc_hd__o2bb2a_4 A1_N A2_N B1 B2 X
*.PININFO A1_N:I A2_N:I B1:I B2:I X:O
.ENDS

.SUBCKT sky130_fd_sc_hd__o2bb2ai_1 A1_N A2_N B1 B2 Y
*.PININFO A1_N:I A2_N:I B1:I B2:I Y:O
.ENDS

.SUBCKT sky130_fd_sc_hd__o2bb2ai_2 A1_N A2_N B1 B2 Y
*.PININFO A1_N:I A2_N:I B1:I B2:I Y:O
.ENDS

.SUBCKT sky130_fd_sc_hd__o2bb2ai_4 A1_N A2_N B1 B2 Y
*.PININFO A1_N:I A2_N:I B1:I B2:I Y:O
.ENDS

.SUBCKT sky130_fd_sc_hd__o311a_1 A1 A2 A3 B1 C1 X
*.PININFO A1:I A2:I A3:I B1:I C1:I X:O
.ENDS

.SUBCKT sky130_fd_sc_hd__o311a_2 A1 A2 A3 B1 C1 X
*.PININFO A1:I A2:I A3:I B1:I C1:I X:O
.ENDS

.SUBCKT sky130_fd_sc_hd__o311a_4 A1 A2 A3 B1 C1 X
*.PININFO A1:I A2:I A3:I B1:I C1:I X:O
.ENDS

.SUBCKT sky130_fd_sc_hd__o311ai_0 A1 A2 A3 B1 C1 Y
*.PININFO A1:I A2:I A3:I B1:I C1:I Y:O
.ENDS

.SUBCKT sky130_fd_sc_hd__o311ai_1 A1 A2 A3 B1 C1 Y
*.PININFO A1:I A2:I A3:I B1:I C1:I Y:O
.ENDS

.SUBCKT sky130_fd_sc_hd__o311ai_2 A1 A2 A3 B1 C1 Y
*.PININFO A1:I A2:I A3:I B1:I C1:I Y:O
.ENDS

.SUBCKT sky130_fd_sc_hd__o311ai_4 A1 A2 A3 B1 C1 Y
*.PININFO A1:I A2:I A3:I B1:I C1:I Y:O
.ENDS

.SUBCKT sky130_fd_sc_hd__o31a_1 A1 A2 A3 B1 X
*.PININFO A1:I A2:I A3:I B1:I X:O
.ENDS

.SUBCKT sky130_fd_sc_hd__o31a_2 A1 A2 A3 B1 X
*.PININFO A1:I A2:I A3:I B1:I X:O
.ENDS

.SUBCKT sky130_fd_sc_hd__o31a_4 A1 A2 A3 B1 X
*.PININFO A1:I A2:I A3:I B1:I X:O
.ENDS

.SUBCKT sky130_fd_sc_hd__o31ai_1 A1 A2 A3 B1 Y
*.PININFO A1:I A2:I A3:I B1:I Y:O
.ENDS

.SUBCKT sky130_fd_sc_hd__o31ai_2 A1 A2 A3 B1 Y
*.PININFO A1:I A2:I A3:I B1:I Y:O
.ENDS

.SUBCKT sky130_fd_sc_hd__o31ai_4 A1 A2 A3 B1 Y
*.PININFO A1:I A2:I A3:I B1:I Y:O
.ENDS

.SUBCKT sky130_fd_sc_hd__o32a_1 A1 A2 A3 B1 B2 X
*.PININFO A1:I A2:I A3:I B1:I B2:I X:O
.ENDS

.SUBCKT sky130_fd_sc_hd__o32a_2 A1 A2 A3 B1 B2 X
*.PININFO A1:I A2:I A3:I B1:I B2:I X:O
.ENDS

.SUBCKT sky130_fd_sc_hd__o32a_4 A1 A2 A3 B1 B2 X
*.PININFO A1:I A2:I A3:I B1:I B2:I X:O
.ENDS

.SUBCKT sky130_fd_sc_hd__o32ai_1 A1 A2 A3 B1 B2 Y
*.PININFO A1:I A2:I A3:I B1:I B2:I Y:O
.ENDS

.SUBCKT sky130_fd_sc_hd__o32ai_2 A1 A2 A3 B1 B2 Y
*.PININFO A1:I A2:I A3:I B1:I B2:I Y:O
.ENDS

.SUBCKT sky130_fd_sc_hd__o32ai_4 A1 A2 A3 B1 B2 Y
*.PININFO A1:I A2:I A3:I B1:I B2:I Y:O
.ENDS

.SUBCKT sky130_fd_sc_hd__o41a_1 A1 A2 A3 A4 B1 X
*.PININFO A1:I A2:I A3:I A4:I B1:I X:O
.ENDS

.SUBCKT sky130_fd_sc_hd__o41a_2 A1 A2 A3 A4 B1 X
*.PININFO A1:I A2:I A3:I A4:I B1:I X:O
.ENDS

.SUBCKT sky130_fd_sc_hd__o41a_4 A1 A2 A3 A4 B1 X
*.PININFO A1:I A2:I A3:I A4:I B1:I X:O
.ENDS

.SUBCKT sky130_fd_sc_hd__o41ai_1 A1 A2 A3 A4 B1 Y
*.PININFO A1:I A2:I A3:I A4:I B1:I Y:O
.ENDS

.SUBCKT sky130_fd_sc_hd__o41ai_2 A1 A2 A3 A4 B1 Y
*.PININFO A1:I A2:I A3:I A4:I B1:I Y:O
.ENDS

.SUBCKT sky130_fd_sc_hd__o41ai_4 A1 A2 A3 A4 B1 Y
*.PININFO A1:I A2:I A3:I A4:I B1:I Y:O
.ENDS

.SUBCKT sky130_fd_sc_hd__or2_0 A B X
*.PININFO A:I B:I X:O
.ENDS

.SUBCKT sky130_fd_sc_hd__or2_1 A B X
*.PININFO A:I B:I X:O
.ENDS

.SUBCKT sky130_fd_sc_hd__or2_2 A B X
*.PININFO A:I B:I X:O
.ENDS

.SUBCKT sky130_fd_sc_hd__or2_4 A B X
*.PININFO A:I B:I X:O
.ENDS

.SUBCKT sky130_fd_sc_hd__or2b_1 A B_N X
*.PININFO A:I B_N:I X:O
.ENDS

.SUBCKT sky130_fd_sc_hd__or2b_2 A B_N X
*.PININFO A:I B_N:I X:O
.ENDS

.SUBCKT sky130_fd_sc_hd__or2b_4 A B_N X
*.PININFO A:I B_N:I X:O
.ENDS

.SUBCKT sky130_fd_sc_hd__or3_1 A B C X
*.PININFO A:I B:I C:I X:O
.ENDS

.SUBCKT sky130_fd_sc_hd__or3_2 A B C X
*.PININFO A:I B:I C:I X:O
.ENDS

.SUBCKT sky130_fd_sc_hd__or3_4 A B C X
*.PININFO A:I B:I C:I X:O
.ENDS

.SUBCKT sky130_fd_sc_hd__or3b_1 A B C_N X
*.PININFO A:I B:I C_N:I X:O
.ENDS

.SUBCKT sky130_fd_sc_hd__or3b_2 A B C_N X
*.PININFO A:I B:I C_N:I X:O
.ENDS

.SUBCKT sky130_fd_sc_hd__or3b_4 A B C_N X
*.PININFO A:I B:I C_N:I X:O
.ENDS

.SUBCKT sky130_fd_sc_hd__or4_1 A B C D X
*.PININFO A:I B:I C:I D:I X:O
.ENDS

.SUBCKT sky130_fd_sc_hd__or4_2 A B C D X
*.PININFO A:I B:I C:I D:I X:O
.ENDS

.SUBCKT sky130_fd_sc_hd__or4_4 A B C D X
*.PININFO A:I B:I C:I D:I X:O
.ENDS

.SUBCKT sky130_fd_sc_hd__or4b_1 A B C D_N X
*.PININFO A:I B:I C:I D_N:I X:O
.ENDS

.SUBCKT sky130_fd_sc_hd__or4b_2 A B C D_N X
*.PININFO A:I B:I C:I D_N:I X:O
.ENDS

.SUBCKT sky130_fd_sc_hd__or4b_4 A B C D_N X
*.PININFO A:I B:I C:I D_N:I X:O
.ENDS

.SUBCKT sky130_fd_sc_hd__or4bb_1 A B C_N D_N X
*.PININFO A:I B:I C_N:I D_N:I X:O
.ENDS

.SUBCKT sky130_fd_sc_hd__or4bb_2 A B C_N D_N X
*.PININFO A:I B:I C_N:I D_N:I X:O
.ENDS

.SUBCKT sky130_fd_sc_hd__or4bb_4 A B C_N D_N X
*.PININFO A:I B:I C_N:I D_N:I X:O
.ENDS

.SUBCKT sky130_fd_sc_hd__probe_p_8 A X
*.PININFO A:I X:O
.ENDS

.SUBCKT sky130_fd_sc_hd__probec_p_8 A X
*.PININFO A:I X:O
.ENDS

.SUBCKT sky130_fd_sc_hd__sdfbbn_1 CLK_N D Q Q_N RESET_B SCD SCE SET_B
*.PININFO CLK_N:I D:I Q:O Q_N:O RESET_B:I SCD:I SCE:I SET_B:I
.ENDS

.SUBCKT sky130_fd_sc_hd__sdfbbn_2 CLK_N D Q Q_N RESET_B SCD SCE SET_B
*.PININFO CLK_N:I D:I Q:O Q_N:O RESET_B:I SCD:I SCE:I SET_B:I
.ENDS

.SUBCKT sky130_fd_sc_hd__sdfbbp_1 CLK D Q Q_N RESET_B SCD SCE SET_B
*.PININFO CLK:I D:I Q:O Q_N:O RESET_B:I SCD:I SCE:I SET_B:I
.ENDS

.SUBCKT sky130_fd_sc_hd__sdfrbp_1 CLK D Q Q_N RESET_B SCD SCE
*.PININFO CLK:I D:I Q:O Q_N:O RESET_B:I SCD:I SCE:I
.ENDS

.SUBCKT sky130_fd_sc_hd__sdfrbp_2 CLK D Q Q_N RESET_B SCD SCE
*.PININFO CLK:I D:I Q:O Q_N:O RESET_B:I SCD:I SCE:I
.ENDS

.SUBCKT sky130_fd_sc_hd__sdfrtn_1 CLK_N D Q RESET_B SCD SCE
*.PININFO CLK_N:I D:I Q:O RESET_B:I SCD:I SCE:I
.ENDS

.SUBCKT sky130_fd_sc_hd__sdfrtp_1 CLK D Q RESET_B SCD SCE
*.PININFO CLK:I D:I Q:O RESET_B:I SCD:I SCE:I
.ENDS

.SUBCKT sky130_fd_sc_hd__sdfrtp_2 CLK D Q RESET_B SCD SCE
*.PININFO CLK:I D:I Q:O RESET_B:I SCD:I SCE:I
.ENDS

.SUBCKT sky130_fd_sc_hd__sdfrtp_4 CLK D Q RESET_B SCD SCE
*.PININFO CLK:I D:I Q:O RESET_B:I SCD:I SCE:I
.ENDS

.SUBCKT sky130_fd_sc_hd__sdfsbp_1 CLK D Q Q_N SCD SCE SET_B
*.PININFO CLK:I D:I Q:O Q_N:O SCD:I SCE:I SET_B:I
.ENDS

.SUBCKT sky130_fd_sc_hd__sdfsbp_2 CLK D Q Q_N SCD SCE SET_B
*.PININFO CLK:I D:I Q:O Q_N:O SCD:I SCE:I SET_B:I
.ENDS

.SUBCKT sky130_fd_sc_hd__sdfstp_1 CLK D Q SCD SCE SET_B
*.PININFO CLK:I D:I Q:O SCD:I SCE:I SET_B:I
.ENDS

.SUBCKT sky130_fd_sc_hd__sdfstp_2 CLK D Q SCD SCE SET_B
*.PININFO CLK:I D:I Q:O SCD:I SCE:I SET_B:I
.ENDS

.SUBCKT sky130_fd_sc_hd__sdfstp_4 CLK D Q SCD SCE SET_B
*.PININFO CLK:I D:I Q:O SCD:I SCE:I SET_B:I
.ENDS

.SUBCKT sky130_fd_sc_hd__sdfxbp_1 CLK D Q Q_N SCD SCE
*.PININFO CLK:I D:I Q:O Q_N:O SCD:I SCE:I
.ENDS

.SUBCKT sky130_fd_sc_hd__sdfxbp_2 CLK D Q Q_N SCD SCE
*.PININFO CLK:I D:I Q:O Q_N:O SCD:I SCE:I
.ENDS

.SUBCKT sky130_fd_sc_hd__sdfxtp_1 CLK D Q SCD SCE
*.PININFO CLK:I D:I Q:O SCD:I SCE:I
.ENDS

.SUBCKT sky130_fd_sc_hd__sdfxtp_2 CLK D Q SCD SCE
*.PININFO CLK:I D:I Q:O SCD:I SCE:I
.ENDS

.SUBCKT sky130_fd_sc_hd__sdfxtp_4 CLK D Q SCD SCE
*.PININFO CLK:I D:I Q:O SCD:I SCE:I
.ENDS

.SUBCKT sky130_fd_sc_hd__sdlclkp_1 CLK GATE GCLK M0 SCE
*.PININFO CLK:I GATE:I GCLK:O M0:B SCE:I
.ENDS

.SUBCKT sky130_fd_sc_hd__sdlclkp_2 CLK GATE GCLK M0 SCE
*.PININFO CLK:I GATE:I GCLK:O M0:B SCE:I
.ENDS

.SUBCKT sky130_fd_sc_hd__sdlclkp_4 CLK GATE GCLK M0 SCE
*.PININFO CLK:I GATE:I GCLK:O M0:B SCE:I
.ENDS

.SUBCKT sky130_fd_sc_hd__sedfxbp_1 CLK D DE Q Q_N SCD SCE
*.PININFO CLK:I D:I DE:I Q:O Q_N:O SCD:I SCE:I
.ENDS

.SUBCKT sky130_fd_sc_hd__sedfxbp_2 CLK D DE Q Q_N SCD SCE
*.PININFO CLK:I D:I DE:I Q:O Q_N:O SCD:I SCE:I
.ENDS

.SUBCKT sky130_fd_sc_hd__sedfxtp_1 CLK D DE Q SCD SCE
*.PININFO CLK:I D:I DE:I Q:O SCD:I SCE:I
.ENDS

.SUBCKT sky130_fd_sc_hd__sedfxtp_2 CLK D DE Q SCD SCE
*.PININFO CLK:I D:I DE:I Q:O SCD:I SCE:I
.ENDS

.SUBCKT sky130_fd_sc_hd__sedfxtp_4 CLK D DE Q SCD SCE
*.PININFO CLK:I D:I DE:I Q:O SCD:I SCE:I
.ENDS

.SUBCKT sky130_fd_sc_hd__xnor2_1 A B Y
*.PININFO A:I B:I Y:O
.ENDS

.SUBCKT sky130_fd_sc_hd__xnor2_2 A B Y
*.PININFO A:I B:I Y:O
.ENDS

.SUBCKT sky130_fd_sc_hd__xnor2_4 A B Y
*.PININFO A:I B:I Y:O
.ENDS

.SUBCKT sky130_fd_sc_hd__xnor3_1 A B C X
*.PININFO A:I B:I C:I X:O
.ENDS

.SUBCKT sky130_fd_sc_hd__xnor3_2 A B C X
*.PININFO A:I B:I C:I X:O
.ENDS

.SUBCKT sky130_fd_sc_hd__xnor3_4 A B C X
*.PININFO A:I B:I C:I X:O
.ENDS

.SUBCKT sky130_fd_sc_hd__xor2_1 A B X
*.PININFO A:I B:I X:O
.ENDS

.SUBCKT sky130_fd_sc_hd__xor2_2 A B X
*.PININFO A:I B:I X:O
.ENDS

.SUBCKT sky130_fd_sc_hd__xor2_4 A B X
*.PININFO A:I B:I X:O
.ENDS

.SUBCKT sky130_fd_sc_hd__xor3_1 A B C X
*.PININFO A:I B:I C:I X:O
.ENDS

.SUBCKT sky130_fd_sc_hd__xor3_2 A B C X
*.PININFO A:I B:I C:I X:O
.ENDS

.SUBCKT sky130_fd_sc_hd__xor3_4 A B C X
*.PININFO A:I B:I C:I X:O
.ENDS
